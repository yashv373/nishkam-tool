beta-multiplier current reference, 10k source resistor, DC vs temperature
.include /foss/pdks/gf180mcuD/libs.tech/ngspice/design.ngspice
.lib /foss/pdks/gf180mcuD/libs.tech/ngspice/sm141064.ngspice typical
Vdd vdd 0 3.3
XM3 g3 g3 vdd vdd pfet_03v3 W=10u L=2u
XM4 g1 g3 vdd vdd pfet_03v3 W=10u L=2u
XM1 g1 g1 0 0 nfet_03v3 W=5u L=2u
XM2 g3 g1 s2 0 nfet_03v3 W=20u L=2u
R1 s2 0 10k
Rst vdd g1 20Meg
.dc temp -40 125 5
.meas dc vg1_m40 find v(g1) at=-40
.meas dc vg1_27 find v(g1) at=27
.meas dc vg1_125 find v(g1) at=125
.meas dc ir_m40 find v(s2) at=-40
.meas dc ir_27 find v(s2) at=27
.meas dc ir_125 find v(s2) at=125
.end
