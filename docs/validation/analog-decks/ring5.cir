5-stage ring oscillator, inverters W=1u/2u L=0.28u, 3.3 V
.include /foss/pdks/gf180mcuD/libs.tech/ngspice/design.ngspice
.lib /foss/pdks/gf180mcuD/libs.tech/ngspice/sm141064.ngspice typical
Vdd vdd 0 3.3
.subckt inv a y vdd
XMN y a 0 0 nfet_03v3 W=1u L=0.28u
XMP y a vdd vdd pfet_03v3 W=2u L=0.28u
.ends
X1 n5 n1 vdd inv
X2 n1 n2 vdd inv
X3 n2 n3 vdd inv
X4 n3 n4 vdd inv
X5 n4 n5 vdd inv
CL n1 0 5f
.ic v(n1)=0 v(n2)=3.3 v(n3)=0 v(n4)=3.3 v(n5)=0
.tran 5p 20n
.meas tran tper trig v(n1) val=1.65 rise=5 targ v(n1) val=1.65 rise=6
.meas tran vmax max v(n1) from=5n to=20n
.meas tran vmin min v(n1) from=5n to=20n
.end
