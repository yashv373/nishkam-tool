5-stage ring oscillator, inverters W=1u/2u L=0.28u, 3.3 V
.include /foss/pdks/gf180mcuD/libs.tech/ngspice/design.ngspice
.lib /foss/pdks/gf180mcuD/libs.tech/ngspice/sm141064.ngspice typical
Vdd vdd 0 3.3
.subckt inv a y vdd
XMN y a 0 0 nfet_03v3 W=1u L=0.28u ad=4.4e-13 as=4.4e-13 pd=2.88e-6 ps=2.88e-6
XMP y a vdd vdd pfet_03v3 W=2u L=0.28u ad=8.8e-13 as=8.8e-13 pd=4.88e-6 ps=4.88e-6
.ends
X1 n5 n1 vdd inv
X2 n1 n2 vdd inv
X3 n2 n3 vdd inv
X4 n3 n4 vdd inv
X5 n4 n5 vdd inv
CL n1 0 5f
.ic v(n1)=0 v(n2)=3.3 v(n3)=0 v(n4)=3.3 v(n5)=0
.control
set filetype=binary
set appendwrite
op
write /op.raw all
print @m.x1.xmn.m0[vth]
print @m.x1.xmn.m0[vdsat]
print @m.x1.xmn.m0[gm]
print @m.x1.xmn.m0[gds]
print @m.x1.xmn.m0[vgs]
print @m.x1.xmn.m0[vds]
print @m.x1.xmn.m0[id]
print @m.x1.xmp.m0[vth]
print @m.x1.xmp.m0[vdsat]
print @m.x1.xmp.m0[gm]
print @m.x1.xmp.m0[gds]
print @m.x1.xmp.m0[vgs]
print @m.x1.xmp.m0[vds]
print @m.x1.xmp.m0[id]
print @m.x2.xmn.m0[vth]
print @m.x2.xmn.m0[vdsat]
print @m.x2.xmn.m0[gm]
print @m.x2.xmn.m0[gds]
print @m.x2.xmn.m0[vgs]
print @m.x2.xmn.m0[vds]
print @m.x2.xmn.m0[id]
print @m.x2.xmp.m0[vth]
print @m.x2.xmp.m0[vdsat]
print @m.x2.xmp.m0[gm]
print @m.x2.xmp.m0[gds]
print @m.x2.xmp.m0[vgs]
print @m.x2.xmp.m0[vds]
print @m.x2.xmp.m0[id]
print @m.x3.xmn.m0[vth]
print @m.x3.xmn.m0[vdsat]
print @m.x3.xmn.m0[gm]
print @m.x3.xmn.m0[gds]
print @m.x3.xmn.m0[vgs]
print @m.x3.xmn.m0[vds]
print @m.x3.xmn.m0[id]
print @m.x3.xmp.m0[vth]
print @m.x3.xmp.m0[vdsat]
print @m.x3.xmp.m0[gm]
print @m.x3.xmp.m0[gds]
print @m.x3.xmp.m0[vgs]
print @m.x3.xmp.m0[vds]
print @m.x3.xmp.m0[id]
print @m.x4.xmn.m0[vth]
print @m.x4.xmn.m0[vdsat]
print @m.x4.xmn.m0[gm]
print @m.x4.xmn.m0[gds]
print @m.x4.xmn.m0[vgs]
print @m.x4.xmn.m0[vds]
print @m.x4.xmn.m0[id]
print @m.x4.xmp.m0[vth]
print @m.x4.xmp.m0[vdsat]
print @m.x4.xmp.m0[gm]
print @m.x4.xmp.m0[gds]
print @m.x4.xmp.m0[vgs]
print @m.x4.xmp.m0[vds]
print @m.x4.xmp.m0[id]
print @m.x5.xmn.m0[vth]
print @m.x5.xmn.m0[vdsat]
print @m.x5.xmn.m0[gm]
print @m.x5.xmn.m0[gds]
print @m.x5.xmn.m0[vgs]
print @m.x5.xmn.m0[vds]
print @m.x5.xmn.m0[id]
print @m.x5.xmp.m0[vth]
print @m.x5.xmp.m0[vdsat]
print @m.x5.xmp.m0[gm]
print @m.x5.xmp.m0[gds]
print @m.x5.xmp.m0[vgs]
print @m.x5.xmp.m0[vds]
print @m.x5.xmp.m0[id]
tran 5p 20n
write /out.raw all
meas tran tper trig v(n1) val=1.65 rise=5 targ v(n1) val=1.65 rise=6
meas tran vmax max v(n1) from=5n to=20n
meas tran vmin min v(n1) from=5n to=20n
.endc
.end
