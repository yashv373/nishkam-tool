StrongARM latch comparator, 5 mV input, 100 MHz clock, 20 fF loads
.include /foss/pdks/gf180mcuD/libs.tech/ngspice/design.ngspice
.lib /foss/pdks/gf180mcuD/libs.tech/ngspice/sm141064.ngspice typical
Vdd vdd 0 3.3
Vclk clk 0 pulse(0 3.3 2n 100p 100p 4.9n 10n)
Vp inp 0 1.655
Vn inn 0 1.650
XMT tail clk 0 0 nfet_03v3 W=8u L=0.28u
XM1 x inp tail 0 nfet_03v3 W=4u L=0.28u
XM2 y inn tail 0 nfet_03v3 W=4u L=0.28u
XM3 outn outp x 0 nfet_03v3 W=2u L=0.28u
XM4 outp outn y 0 nfet_03v3 W=2u L=0.28u
XM5 outn outp vdd vdd pfet_03v3 W=4u L=0.28u
XM6 outp outn vdd vdd pfet_03v3 W=4u L=0.28u
XM7 outn clk vdd vdd pfet_03v3 W=2u L=0.28u
XM8 outp clk vdd vdd pfet_03v3 W=2u L=0.28u
XM9 x clk vdd vdd pfet_03v3 W=2u L=0.28u
XM10 y clk vdd vdd pfet_03v3 W=2u L=0.28u
CP outp 0 20f
CN outn 0 20f
.tran 10p 30n
.meas tran tdec_n trig v(clk) val=1.65 rise=1 targ v(outn) val=1.65 fall=1
.meas tran voutn_end find v(outn) at=6n
.meas tran voutp_end find v(outp) at=6n
.end
