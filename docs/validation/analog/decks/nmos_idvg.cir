nmos idvg nfet_03v3 W=1u L=0.28u
.include /foss/pdks/gf180mcuD/libs.tech/ngspice/design.ngspice
.lib /foss/pdks/gf180mcuD/libs.tech/ngspice/sm141064.ngspice typical
Vd d 0 0.1
Vg g 0 0
xm1 d g 0 0 nfet_03v3 W=1u L=0.28u
.control
set filetype=ascii
dc Vg 0 3.3 0.01 Vd 0.1 3.3 3.2
write nmos_idvg.raw v(g) i(Vd)
alter Vg=1.65
alter Vd=1.65
op
print i(Vd)
print @m.xm1.m0[vth] @m.xm1.m0[vdsat] @m.xm1.m0[gm] @m.xm1.m0[vgs] @m.xm1.m0[vds]
.endc
.end
