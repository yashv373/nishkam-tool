5T OTA open-loop AC, 20 uA tail, 1 pF load, corner typical
.include /foss/pdks/gf180mcuD/libs.tech/ngspice/design.ngspice
.lib /foss/pdks/gf180mcuD/libs.tech/ngspice/sm141064.ngspice typical
.param wn=10u lgn=1u wp=20u lgp=1u ib=20u
Vdd vdd 0 3.3
VCP inp 0 1.65 AC 0.5
VCN inn 0 1.65 AC 0.5 180
IB vdd nb {ib}
XM3 d3 d3 vdd vdd pfet_03v3 W={wp} L={lgp} ad={(wp)*0.44u} as={(wp)*0.44u} pd={2*((wp)+0.44u)} ps={2*((wp)+0.44u)}
XM4 out d3 vdd vdd pfet_03v3 W={wp} L={lgp} ad={(wp)*0.44u} as={(wp)*0.44u} pd={2*((wp)+0.44u)} ps={2*((wp)+0.44u)}
XM1 d3 inp tail 0 nfet_03v3 W={wn} L={lgn} ad={(wn)*0.44u} as={(wn)*0.44u} pd={2*((wn)+0.44u)} ps={2*((wn)+0.44u)}
XM2 out inn tail 0 nfet_03v3 W={wn} L={lgn} ad={(wn)*0.44u} as={(wn)*0.44u} pd={2*((wn)+0.44u)} ps={2*((wn)+0.44u)}
XM5 tail nb 0 0 nfet_03v3 W={wn} L={lgn} ad={(wn)*0.44u} as={(wn)*0.44u} pd={2*((wn)+0.44u)} ps={2*((wn)+0.44u)}
XM6 nb nb 0 0 nfet_03v3 W={wn} L={lgn} ad={(wn)*0.44u} as={(wn)*0.44u} pd={2*((wn)+0.44u)} ps={2*((wn)+0.44u)}
CL out 0 1p
.control
set filetype=binary
set appendwrite
op
write /op.raw all
print @m.xm3.m0[vth]
print @m.xm3.m0[vdsat]
print @m.xm3.m0[gm]
print @m.xm3.m0[gds]
print @m.xm3.m0[vgs]
print @m.xm3.m0[vds]
print @m.xm3.m0[id]
print @m.xm4.m0[vth]
print @m.xm4.m0[vdsat]
print @m.xm4.m0[gm]
print @m.xm4.m0[gds]
print @m.xm4.m0[vgs]
print @m.xm4.m0[vds]
print @m.xm4.m0[id]
print @m.xm1.m0[vth]
print @m.xm1.m0[vdsat]
print @m.xm1.m0[gm]
print @m.xm1.m0[gds]
print @m.xm1.m0[vgs]
print @m.xm1.m0[vds]
print @m.xm1.m0[id]
print @m.xm2.m0[vth]
print @m.xm2.m0[vdsat]
print @m.xm2.m0[gm]
print @m.xm2.m0[gds]
print @m.xm2.m0[vgs]
print @m.xm2.m0[vds]
print @m.xm2.m0[id]
print @m.xm5.m0[vth]
print @m.xm5.m0[vdsat]
print @m.xm5.m0[gm]
print @m.xm5.m0[gds]
print @m.xm5.m0[vgs]
print @m.xm5.m0[vds]
print @m.xm5.m0[id]
print @m.xm6.m0[vth]
print @m.xm6.m0[vdsat]
print @m.xm6.m0[gm]
print @m.xm6.m0[gds]
print @m.xm6.m0[vgs]
print @m.xm6.m0[vds]
print @m.xm6.m0[id]
ac dec 20 1 1G
write /out.raw all
meas ac gain_dc find vdb(out) at=1
meas ac ugf when vdb(out)=0 fall=1
meas ac ph_ugf find vp(out) when vdb(out)=0 fall=1
.endc
.end
