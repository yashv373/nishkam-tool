nmos 1:1 current mirror, Iref 10 uA, W=2u L=1u
.include /foss/pdks/gf180mcuD/libs.tech/ngspice/design.ngspice
.lib /foss/pdks/gf180mcuD/libs.tech/ngspice/sm141064.ngspice typical
Iref 0 ref 10u
Vo out 0 0
xm1 ref ref 0 0 nfet_03v3 W=2u L=1u
xm2 out ref 0 0 nfet_03v3 W=2u L=1u
.control
set filetype=ascii
dc Vo 0 3.3 0.01
write mirror.raw i(Vo) v(ref)
alter Vo=1.65
op
print i(Vo)
print @m.xm1.m0[vgs] @m.xm1.m0[vth] @m.xm1.m0[vdsat] @m.xm1.m0[vds]
print @m.xm2.m0[vgs] @m.xm2.m0[vth] @m.xm2.m0[vdsat] @m.xm2.m0[vds]
.endc
.end
