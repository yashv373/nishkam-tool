two-stage Miller op-amp, unity-feedback DC via 1 GH inductor, open-loop AC
.include /foss/pdks/gf180mcuD/libs.tech/ngspice/design.ngspice
.lib /foss/pdks/gf180mcuD/libs.tech/ngspice/sm141064.ngspice typical
Vdd vdd 0 3.3
Vcm inp 0 1.65 AC 1
IB vdd nb 20u
XM8 nb nb 0 0 nfet_03v3 W=10u L=1u
XM5 tail nb 0 0 nfet_03v3 W=10u L=1u
XM1 d3 inn tail 0 nfet_03v3 W=20u L=1u
XM2 d4 inp tail 0 nfet_03v3 W=20u L=1u
XM3 d3 d3 vdd vdd pfet_03v3 W=20u L=1u
XM4 d4 d3 vdd vdd pfet_03v3 W=20u L=1u
XM6 out d4 vdd vdd pfet_03v3 W=80u L=1u
XM7 out nb 0 0 nfet_03v3 W=40u L=1u
Cc d4 out 1p
CL out 0 2p
Lfb out inn 1G
Cfb inn 0 1k
.control
set filetype=binary
set appendwrite
op
write /op.raw all
print @m.xm8.m0[vth]
print @m.xm8.m0[vdsat]
print @m.xm8.m0[gm]
print @m.xm8.m0[gds]
print @m.xm8.m0[vgs]
print @m.xm8.m0[vds]
print @m.xm8.m0[id]
print @m.xm5.m0[vth]
print @m.xm5.m0[vdsat]
print @m.xm5.m0[gm]
print @m.xm5.m0[gds]
print @m.xm5.m0[vgs]
print @m.xm5.m0[vds]
print @m.xm5.m0[id]
print @m.xm1.m0[vth]
print @m.xm1.m0[vdsat]
print @m.xm1.m0[gm]
print @m.xm1.m0[gds]
print @m.xm1.m0[vgs]
print @m.xm1.m0[vds]
print @m.xm1.m0[id]
print @m.xm2.m0[vth]
print @m.xm2.m0[vdsat]
print @m.xm2.m0[gm]
print @m.xm2.m0[gds]
print @m.xm2.m0[vgs]
print @m.xm2.m0[vds]
print @m.xm2.m0[id]
print @m.xm3.m0[vth]
print @m.xm3.m0[vdsat]
print @m.xm3.m0[gm]
print @m.xm3.m0[gds]
print @m.xm3.m0[vgs]
print @m.xm3.m0[vds]
print @m.xm3.m0[id]
print @m.xm4.m0[vth]
print @m.xm4.m0[vdsat]
print @m.xm4.m0[gm]
print @m.xm4.m0[gds]
print @m.xm4.m0[vgs]
print @m.xm4.m0[vds]
print @m.xm4.m0[id]
print @m.xm6.m0[vth]
print @m.xm6.m0[vdsat]
print @m.xm6.m0[gm]
print @m.xm6.m0[gds]
print @m.xm6.m0[vgs]
print @m.xm6.m0[vds]
print @m.xm6.m0[id]
print @m.xm7.m0[vth]
print @m.xm7.m0[vdsat]
print @m.xm7.m0[gm]
print @m.xm7.m0[gds]
print @m.xm7.m0[vgs]
print @m.xm7.m0[vds]
print @m.xm7.m0[id]
ac dec 20 1 1G
meas ac gain_dc find vdb(out) at=1
meas ac ugf when vdb(out)=0 fall=1
meas ac ph_ugf find vp(out) when vdb(out)=0 fall=1
write /out.raw all
.endc
.end
